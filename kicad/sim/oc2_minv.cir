* OC2 house-doorbell sense -- minimum detectable line voltage.
* As Vin drops, IF drops -> Ic capability drops -> the collector eventually
* can't be pulled below the ESP32 logic-low threshold. Find that crossing.
* Pass/detect while V(coll) < ~0.825 V (V_IL).

.param beta=200 CTR=1.1

Vin   a 0 DC 0
Vsense a a2 0
Dled  a2 c DLED
Rlim  c 0 5.1k

Q1   coll base emit QOPTO
Bb   0 base I = (CTR/beta)*i(Vsense)
Vdd  vdd 0 3.3
Rpu  vdd coll 45k
Remit emit 0 1k

.model DLED  D(Is=1e-16 N=1.6 Rs=5)
.model QOPTO NPN(BF=200 Is=1e-15 Vaf=100)

.control
echo "  CTR    Vin_min(V)   IF_at_min(mA)"
foreach k 0.5 1.1 2.6
  alterparam CTR = $k
  reset
  dc Vin 0 4 0.002
  meas dc vmin     WHEN v(coll)=0.825 FALL=1
  let ifm = i(Vsense)*1000
  meas dc ifatmin  FIND ifm WHEN v(coll)=0.825 FALL=1
  echo "  $k     -> see vmin / ifatmin above"
end
.endc
.end
