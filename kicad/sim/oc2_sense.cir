* OC2 house-doorbell (Tuerruf) sense stage -- margin check
*
* Models the Tuerruf sense path from doorbell_design.py:
*   line4(IN_P4) -- 12VDC -- line1(P1)
*     -> OC2 LED -> R_lim1 (5.1k) -> P1
*     -> OC2 phototransistor: collector -> GPIO3 (internal ~45k pull-up),
*        emitter -> R_em (1k) -> GND
* Pass criterion: V(coll) drops well below the ESP32 logic-low threshold
* (V_IL ~= 0.25*3.3 = 0.825 V) when Tuerruf is present.
*
* The optocoupler is modelled as: a real LED setting IF, and a real NPN whose
* base is driven by a current source = (CTR/beta)*IF. In the active region this
* gives Ic = CTR*IF; against the weak pull-up the NPN saturates and VCE_sat
* emerges from the model -- which is the whole question.

.param CTR=1.1 beta=200      ; LTV-217-B effective CTR at ~2 mA (derated from 130% @ 5mA)

* ---- LED (input) side ----
Vturruf a 0 DC 12
Vsense  a a2 0               ; 0V ammeter -> I(Vsense) = IF
Dled    a2 c DLED
Rlim    c 0 5.1k             ; R_lim1 back to P1 (gnd)

* ---- phototransistor (output) side ----
Q1   coll base emit QOPTO
Fb   0 base Vsense {CTR/beta}   ; photo base-current = (CTR/beta)*IF -> Ic = CTR*IF
Vdd  vdd 0 3.3
Rpu  vdd coll 45k           ; ESP32-C6 internal pull-up (weak)
Remit emit 0 1k             ; R_em

* ---- device models ----
.model DLED  D(Is=1e-16 N=1.6 Rs=5)      ; ~1.27 V Vf at 2 mA (value non-critical; Rlim dominates)
.model QOPTO NPN(BF=200 Is=1e-15 Vaf=100)

* ---- analysis: sweep Tuerruf 0..12 V, watch the collector ----
.control
dc Vturruf 0 12 0.1
let vil = 0.825
print v(coll) i(Vsense)
* report worst-case (full 12 V) operating point
meas dc vcoll_at12 FIND v(coll) AT=12
meas dc if_at12    FIND i(Vsense) AT=12
.endc
.end
