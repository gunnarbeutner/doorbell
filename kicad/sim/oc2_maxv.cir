* OC2 input stage -- find the survival ceiling on the IN_P4<->P1 pair (continuous DC).
* Which component hits its rating first as the applied voltage rises?
*   R_lim1 : 0603, ~0.1 W (0.125 W premium)         -> power limit
*   OC LED : PC817/LTV-217 abs-max IF ~= 50 mA       -> current limit

Vin   a 0 DC 0
Vsense a a2 0
Dled  a2 c DLED
Rlim  c 0 5.1k

.model DLED D(Is=1e-16 N=1.6 Rs=5)

.control
dc Vin 0 300 0.05
let p_rlim = i(Vsense)*i(Vsense)*5100
meas dc v_rlim_100mw WHEN p_rlim=0.10
meas dc v_rlim_125mw WHEN p_rlim=0.125
meas dc v_rlim_250mw WHEN p_rlim=0.25
meas dc v_led_50mA   WHEN i(Vsense)=0.050
.endc
.end
