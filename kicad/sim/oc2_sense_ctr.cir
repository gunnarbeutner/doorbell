* OC2 house-doorbell (Tuerruf) sense -- worst-case sweep over CTR and line voltage
* Reports V(coll) at the operating point for combinations of:
*   CTR  : 0.5 (abused low) .. 2.6 (LTV-217-B max)
*   Vline: 10 V (sagged Tuerruf) and 12 V (nominal)
* Pass: V(coll) < 0.825 V (ESP32 V_IL).

.param beta=200 CTR=1.1

Vturruf a 0 DC 12
Vsense  a a2 0
Dled    a2 c DLED
Rlim    c 0 5.1k

Q1   coll base emit QOPTO
Bb   0 base I = (CTR/beta)*i(Vsense)
Vdd  vdd 0 3.3
Rpu  vdd coll 45k
Remit emit 0 1k

.model DLED  D(Is=1e-16 N=1.6 Rs=5)
.model QOPTO NPN(BF=200 Is=1e-15 Vaf=100)

.control
echo "  CTR   Vline   IF(mA)    V(coll)"
foreach v 10 12
  foreach k 0.5 1.1 1.8 2.6
    alterparam CTR = $k
    reset
    alter Vturruf dc = $v
    op
    let ifma = i(Vsense)*1000
    let vc = v(coll)
    echo "  $k   $v V   " $&ifma "  " $&vc
  end
end
.endc
.end
